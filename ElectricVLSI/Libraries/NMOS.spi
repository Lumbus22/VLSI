*** SPICE deck for cell NMOS{sch} from library LAB1
*** Created on Wed Feb 18, 2026 14:40:36
*** Last revised on Wed Feb 18, 2026 14:58:30
*** Written on Wed Feb 18, 2026 15:18:53 by Electric VLSI Design System, version 9.08
*** Layout tech: mocmos, foundry MOSIS
*** UC SPICE *** , MIN_RESIST 4.0, MIN_CAPAC 0.1FF

.global gnd

*** TOP LEVEL CELL: NMOS{sch}
Mnmos-4@0 D G gnd gnd CMOSN L=0.2U W=0.3U

* Spice Code nodes in cell cell 'NMOS{sch}'
vd  D  0  dc  0
vs  S  0  dc  0
vg G 0 dc 0
.dc  vd  0  3  1m vg  0   3   0.5
.include  C:\Users\enslenc1\AppData\Local\LTspice\lib\sub\tsmc018.lib
.END
