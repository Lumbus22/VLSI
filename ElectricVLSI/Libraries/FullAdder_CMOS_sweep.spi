*** SPICE deck for cell FullAdder{sch} from library FullAdder_CMOS
*** Transistor-level implementation (9 NAND gates, 36 transistors)
*** Parametric width sweep variant
*** Written by Claude Code from FullAdder_CMOS.jelib
*** Layout tech: mocmos, foundry MOSIS
*** UC SPICE ***, MIN_RESIST 4.0, MIN_CAPAC 0.1FF

.global gnd vdd

*** Parameterized transistor widths
.param Wn=0.3u
.step param Wp list 0.6u 0.9u 1.2u

*** TOP LEVEL CELL: FullAdder{sch}

* NAND0: NAND(A, B) -> n0
Mn0a n0 A mid0 gnd CMOSN L=0.2U W={Wn}
Mn0b mid0 B gnd gnd CMOSN L=0.2U W={Wn}
Mp0a n0 A vdd vdd CMOSP L=0.2U W={Wp}
Mp0b n0 B vdd vdd CMOSP L=0.2U W={Wp}

* NAND1: NAND(A, n0) -> n1
Mn1a n1 A mid1 gnd CMOSN L=0.2U W={Wn}
Mn1b mid1 n0 gnd gnd CMOSN L=0.2U W={Wn}
Mp1a n1 A vdd vdd CMOSP L=0.2U W={Wp}
Mp1b n1 n0 vdd vdd CMOSP L=0.2U W={Wp}

* NAND2: NAND(n0, B) -> n2
Mn2a n2 n0 mid2 gnd CMOSN L=0.2U W={Wn}
Mn2b mid2 B gnd gnd CMOSN L=0.2U W={Wn}
Mp2a n2 n0 vdd vdd CMOSP L=0.2U W={Wp}
Mp2b n2 B vdd vdd CMOSP L=0.2U W={Wp}

* NAND3: NAND(n1, n2) -> n3  [A XOR B]
Mn3a n3 n1 mid3 gnd CMOSN L=0.2U W={Wn}
Mn3b mid3 n2 gnd gnd CMOSN L=0.2U W={Wn}
Mp3a n3 n1 vdd vdd CMOSP L=0.2U W={Wp}
Mp3b n3 n2 vdd vdd CMOSP L=0.2U W={Wp}

* NAND4: NAND(n3, Cin) -> n4
Mn4a n4 n3 mid4 gnd CMOSN L=0.2U W={Wn}
Mn4b mid4 Cin gnd gnd CMOSN L=0.2U W={Wn}
Mp4a n4 n3 vdd vdd CMOSP L=0.2U W={Wp}
Mp4b n4 Cin vdd vdd CMOSP L=0.2U W={Wp}

* NAND5: NAND(n0, n4) -> Cout  [Carry out]
Mn5a Cout n0 mid5 gnd CMOSN L=0.2U W={Wn}
Mn5b mid5 n4 gnd gnd CMOSN L=0.2U W={Wn}
Mp5a Cout n0 vdd vdd CMOSP L=0.2U W={Wp}
Mp5b Cout n4 vdd vdd CMOSP L=0.2U W={Wp}

* NAND6: NAND(n3, n4) -> n6
Mn6a n6 n3 mid6 gnd CMOSN L=0.2U W={Wn}
Mn6b mid6 n4 gnd gnd CMOSN L=0.2U W={Wn}
Mp6a n6 n3 vdd vdd CMOSP L=0.2U W={Wp}
Mp6b n6 n4 vdd vdd CMOSP L=0.2U W={Wp}

* NAND7: NAND(n4, Cin) -> n7
Mn7a n7 n4 mid7 gnd CMOSN L=0.2U W={Wn}
Mn7b mid7 Cin gnd gnd CMOSN L=0.2U W={Wn}
Mp7a n7 n4 vdd vdd CMOSP L=0.2U W={Wp}
Mp7b n7 Cin vdd vdd CMOSP L=0.2U W={Wp}

* NAND8: NAND(n6, n7) -> Sum  [Sum output]
Mn8a Sum n6 mid8 gnd CMOSN L=0.2U W={Wn}
Mn8b mid8 n7 gnd gnd CMOSN L=0.2U W={Wn}
Mp8a Sum n6 vdd vdd CMOSP L=0.2U W={Wp}
Mp8b Sum n7 vdd vdd CMOSP L=0.2U W={Wp}

*** FO4 Load Subcircuit (minimum-sized inverter)
.subckt fo4_inv in out vdd gnd
Mn out in gnd gnd CMOSN W=0.3U L=0.2U
Mp out in vdd vdd CMOSP W=0.6U L=0.2U
.ends fo4_inv

*** FO4 loads on Sum output (fan-out of 4)
Xfo4_sum1 Sum sum_fo1 vdd gnd fo4_inv
Xfo4_sum2 Sum sum_fo2 vdd gnd fo4_inv
Xfo4_sum3 Sum sum_fo3 vdd gnd fo4_inv
Xfo4_sum4 Sum sum_fo4 vdd gnd fo4_inv

*** FO4 loads on Cout output (fan-out of 4)
Xfo4_cout1 Cout cout_fo1 vdd gnd fo4_inv
Xfo4_cout2 Cout cout_fo2 vdd gnd fo4_inv
Xfo4_cout3 Cout cout_fo3 vdd gnd fo4_inv
Xfo4_cout4 Cout cout_fo4 vdd gnd fo4_inv

*** Input voltage sources (all 8 combinations in 80ns cycle)
vdd vdd 0 DC 3
vA A 0 PULSE (0 3 0 0.001ns 0.001ns 10ns 20ns)
vB B 0 PULSE (0 3 0 0.001ns 0.001ns 20ns 40ns)
vCin Cin 0 PULSE (0 3 0 0.001ns 0.001ns 40ns 80ns)

*** Load capacitances
c1 Sum 0 100f
c2 Cout 0 100f

*** Transistor models
.include /home/laptop/Documents/GitHub/VLSI/ElectricVLSI/TransistorSpecs/tsmc018.lib

*** Transient analysis (2 full input cycles)
.tran 0 160n

*** Measurements - Sum timing (VDD=3V: 10%=0.3V, 50%=1.5V, 90%=2.7V)
.meas TRAN rise_sum  TRIG v(Sum)  VAL=0.3 RISE=1 TARG v(Sum)  VAL=2.7 RISE=1
.meas TRAN fall_sum  TRIG v(Sum)  VAL=2.7 FALL=1 TARG v(Sum)  VAL=0.3 FALL=1
.meas TRAN tplh_sum  TRIG v(A)    VAL=1.5 RISE=1 TARG v(Sum)  VAL=1.5 RISE=1
.meas TRAN tphl_sum  TRIG v(A)    VAL=1.5 FALL=1 TARG v(Sum)  VAL=1.5 FALL=1

*** Measurements - Cout timing
.meas TRAN rise_cout TRIG v(Cout) VAL=0.3 RISE=1 TARG v(Cout) VAL=2.7 RISE=1
.meas TRAN fall_cout TRIG v(Cout) VAL=2.7 FALL=1 TARG v(Cout) VAL=0.3 FALL=1
.meas TRAN tplh_cout TRIG v(A)    VAL=1.5 RISE=1 TARG v(Cout) VAL=1.5 RISE=1
.meas TRAN tphl_cout TRIG v(A)    VAL=1.5 FALL=1 TARG v(Cout) VAL=1.5 FALL=1

.END
