*** SPICE deck for cell NANDNet{lay} from library NeuralNets
*** Created on Wed May 13, 2026 10:15:49
*** Last revised on Thu May 21, 2026 15:10:47
*** Written on Thu May 21, 2026 15:10:56 by Electric VLSI Design System, version 9.08
*** Layout tech: mocmos, foundry MOSIS
*** UC SPICE *** , MIN_RESIST 4.0, MIN_CAPAC 0.1FF

*** TOP LEVEL CELL: NANDNet{lay}
Mnmos@0 net@1 netOut gnd gnd CMOSN L=0.2U W=0.3U AS=1.333P AD=0.41P PS=6.8U PD=2.7U
Mnmos@1 netOut A gnd gnd CMOSN L=0.3U W=0.3U AS=1.333P AD=0.367P PS=6.8U PD=2.567U
Mnmos@2 netOut B gnd gnd CMOSN L=0.3U W=0.3U AS=1.333P AD=0.367P PS=6.8U PD=2.567U
Mnmos@3 out net@1 gnd gnd CMOSN L=0.2U W=0.3U AS=1.333P AD=0.41P PS=6.8U PD=2.7U
Mpmos@0 net@1 netOut vdd vdd CMOSP L=0.2U W=0.6U AS=1.46P AD=0.41P PS=7.067U PD=2.7U
Mpmos@1 vdd vBias netOut vdd CMOSP L=0.2U W=0.6U AS=0.367P AD=1.46P PS=2.567U PD=7.067U
Mpmos@2 out net@1 vdd vdd CMOSP L=0.2U W=0.6U AS=1.46P AD=0.41P PS=7.067U PD=2.7U

* Spice Code nodes in cell cell 'NANDNet{lay}'
* --- Neuromorphic NAND Gate Testbench ---
* 1. Supply Voltage
* Note: TSMC 0.18um typically uses a 1.8V core voltage. If your layout
* uses 3.3V thick-oxide I/O devices, change this 1.8 to 3.0 or 3.3.
vdd vdd 0 DC 1.8
* 2. Analog Bias Reference Voltage (V_REF)
* Instead of a static DC voltage, we define a parameter to sweep the bias.
* This will simulate how tuning V_REF changes the neuron's logic threshold.
.param VBIAS = 0.8
vRef vRef 0 DC {VBIAS}
* Sweep VBIAS from 0.5V to 1.5V in 0.1V increments to find the exact NAND threshold
.step param VBIAS 0.5 1.5 0.1
* 3. Input Stimulus (Testing the Truth Table)
* Pulse format: (V_initial V_peak T_delay T_rise T_fall Pulse_Width Period)
* Input A pulses every 20ns
vA A 0 PULSE (0 1.8 0 0.1n 0.1n 10n 20n)
* Input B pulses every 40ns.
* Combined with A, this tests states: 00 (0-10ns), 10 (10-20ns), 01 (20-30ns), 11 (30-40ns)
vB B 0 PULSE (0 1.8 0 0.1n 0.1n 20n 40n)
* 4. Output Load Capacitance
* Simulates parasitic routing or oscilloscope probe capacitance
cf V_OUT 0 200fF
* 5. Analysis
* Run transient analysis for 50ns to capture a full cycle of all four states
.tran 0.1n 50n
* 6. Library Include
.include "C:\Users\coleb\Documents\GitHub\VLSI\ElectricVLSI\TransistorSpecs\tsmc018.lib"
.END
